* OTDB-APW Rev D Full Signal-Path SPICE Netlist (Release Repair 004)
* Split Regulators: U7A/U7B ADP7118AUJZ-3.3-R7 (+3.3V), U8 ADM8829ARTZ (-4.93V CP), U7C ADP7182AUJZ-2.5-R7 (-2.5V)
* Dual DAC Nulling: U3A/U3B AD5683RBRMZ (16-bit) -> U6B ADA4522-2 (-0.10x summing) -> U2 AD8421 REF
V_POS +3V3_A 0 DC 3.300
V_NEG -2V5_AVSS 0 DC -2.500
V_CM VCM_1V1 0 DC 1.100
V_3W_DIFF BRIDGE_MID_SENSE BRIDGE_MID_REF SIN(0 218.5u 36.0)
V_1W_RESID BRIDGE_MID_REF VCM_1V1 SIN(0 1.9073u 12.0)
* AD8421 Instrumentation Amplifier (G = 1 + 9.9k / 100R = 100.000)
E_INA V3W_INA_OUT VDAC_NULL_OUT BRIDGE_MID_SENSE BRIDGE_MID_REF 100.000
V_DAC_NULL VDAC_NULL_OUT 0 DC 1.100
* Anti-Aliasing Filter (R_AAF = 100 Ohm, C_AAF = 10 nF C0G, fc = 159154.94 Hz)
R_AAF V3W_INA_OUT V3W_AAF_OUT 100.0
C_AAF V3W_AAF_OUT 0 10n
.TRAN 100u 0.25
.END
